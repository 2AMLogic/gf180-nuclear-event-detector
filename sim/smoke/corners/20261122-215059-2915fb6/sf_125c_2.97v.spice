* smoke @ sf_125c_2.97v -- GENERATED by sim/harness, do not edit
* corner=sf (slow NMOS / fast PMOS; other families typical)
* temp=125.0 C  vdd=2.97 V  pdk=gf180mcuD@open_pdks f6eeac7dad085ffcc829ccfd721f7b4ce39edcf7

* ---- PVT parameters -------------------------------------------------
.param vdd_nom=3.3
.param vdd_val=2.97
.param temp_c=125.0

* ---- gf180 models -----------------------------------------------
.include "/home/ubuntu/.ciel/gf180mcuD/libs.tech/ngspice/design.ngspice"
.lib "/home/ubuntu/.ciel/gf180mcuD/libs.tech/ngspice/sm141064.ngspice" sf
.lib "/home/ubuntu/.ciel/gf180mcuD/libs.tech/ngspice/sm141064.ngspice" res_typical
.lib "/home/ubuntu/.ciel/gf180mcuD/libs.tech/ngspice/sm141064.ngspice" bjt_typical
.lib "/home/ubuntu/.ciel/gf180mcuD/libs.tech/ngspice/sm141064.ngspice" diode_typical
.lib "/home/ubuntu/.ciel/gf180mcuD/libs.tech/ngspice/sm141064.ngspice" moscap_typical
.lib "/home/ubuntu/.ciel/gf180mcuD/libs.tech/ngspice/sm141064.ngspice" mimcap_typical

.temp 125.0

* ---- testbench ------------------------------------------------------
.include "/home/ubuntu/GitHub/gf180-nuclear-event-detector/.loom/worktrees/issue-16/sim/smoke/corners/20261122-215059-2915fb6/frozen/tb_smoke.spice"

* ---- measurement ----------------------------------------------------
.control
set numdgt=10
set noaskquit
  op
  let m_id_ua = i(vmeas)*1e6
  print m_id_ua
.endc
.end
