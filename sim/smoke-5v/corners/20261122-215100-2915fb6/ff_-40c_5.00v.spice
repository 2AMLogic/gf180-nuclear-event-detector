* smoke-5v @ ff_-40c_5.00v -- GENERATED by sim/harness, do not edit
* corner=ff (every device family fast)
* temp=-40.0 C  vdd=5.0 V  pdk=gf180mcuD@open_pdks f6eeac7dad085ffcc829ccfd721f7b4ce39edcf7

* ---- PVT parameters -------------------------------------------------
.param vdd_nom=5.0
.param vdd_val=5.0
.param temp_c=-40.0

* ---- gf180 models -----------------------------------------------
.include "/home/ubuntu/.ciel/gf180mcuD/libs.tech/ngspice/design.ngspice"
.lib "/home/ubuntu/.ciel/gf180mcuD/libs.tech/ngspice/sm141064.ngspice" ff
.lib "/home/ubuntu/.ciel/gf180mcuD/libs.tech/ngspice/sm141064.ngspice" res_ff
.lib "/home/ubuntu/.ciel/gf180mcuD/libs.tech/ngspice/sm141064.ngspice" bjt_ff
.lib "/home/ubuntu/.ciel/gf180mcuD/libs.tech/ngspice/sm141064.ngspice" diode_ff
.lib "/home/ubuntu/.ciel/gf180mcuD/libs.tech/ngspice/sm141064.ngspice" moscap_ff
.lib "/home/ubuntu/.ciel/gf180mcuD/libs.tech/ngspice/sm141064.ngspice" mimcap_ff

.temp -40.0
.options gmin=1e-18

* ---- testbench ------------------------------------------------------
.include "/home/ubuntu/GitHub/gf180-nuclear-event-detector/.loom/worktrees/issue-16/sim/smoke-5v/corners/20261122-215100-2915fb6/frozen/tb_smoke_5v.spice"

* ---- measurement ----------------------------------------------------
.control
set numdgt=10
set noaskquit
  op
  let m_id6_ua = i(vmeas6)*1e6
  let m_dio_na = i(vdio)*1e9
  let m_res_ua = i(vrm)*1e6
  print m_id6_ua
  print m_dio_na
  print m_res_ua
.endc
.end
